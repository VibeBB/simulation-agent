Buck output RC ripple filter
V1 in 0 DC 5 AC 1
.param Rseries=1k Cfilter=1u
R1 in out {Rseries}
C1 out 0 {Cfilter}
.end
